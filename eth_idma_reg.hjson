{
    name: "eth_idma",
    clock_primary: "msoc_clk",
    reset_primary: "rst_int",
    bus_interfaces: [
        { protocol: "reg_iface", direction: "device"}
    ]
    regwidth: "64",
    registers: [
        { name: "maclo_addr",
          desc: "Configures the lower 4 bytes of the devices MAC address",
          swaccess: "rw",
          hwaccess: "hro",
          fields: [
              { bits: "31:0", name: "lower_mac_address",
                desc: "Lower 32 bit of the devices MAC address"
                resval: "8980226"
              }
          ]
        },
        { name: "machi_mdio",
          desc: "Configures the: upper 2 bytes of the devices MAC address, promiscuous flag, MDIO interface",
          swaccess: "rw",
          hwaccess: "hro",
          fields: [
              { bits: "15:0", name: "upper_mac_address",
                desc: "Upper 16 bit of the devices MAC address"
                resval: "8961"
              },
              { bits: "16", name: "promiscuous",
                desc: "promiscuous flag"
              },
              { bits: "17", name: "phy_mdclk",
                desc: "MDIO clock"
              },
              { bits: "18", name: "phy_mdio_o",
                desc: "MDIO output"
              },
              { bits: "19", name: "phy_mdio_oe",
                desc: "MDIO output enable"
              }
          ]
        },
        { name: "tx_fcs",
          desc: "The FCS TX status",
          swaccess: "ro",
          hwaccess: "hwo",
          fields: [
              { bits: "31:0", name: "tx_fcs_reg",
                desc: "FCS TX status"
              }
          ]
        },
        { name: "rx_fcs",
          desc: "The FCS RX status",
          swaccess: "ro",
          hwaccess: "hwo",
          fields: [
              { bits: "31:0", name: "rx_fcs_reg",
                desc: "FCS RX status"
              }
          ]
        },
        { name: "src_addr",
          desc: "Source Address",
          swaccess: "rw",
          hwaccess: "hro",
          fields: [
            { bits: "31:0",
              name: "src_addr",
              desc: "Source Address"
            }
          ]
        },
        { name: "dst_addr",
          desc: "Destination Address",
          swaccess: "rw",
          hwaccess: "hro",
          fields: [
            { bits: "31:0",
              name: "dst_addr",
              desc: "Destination Address"
            }
          ]
        },
        { name: "num_bytes",
          desc: "Number of bytes",
          swaccess: "rw",
          hwaccess: "hro",
          fields: [
            { bits: "31:0",
              name: "num_bytes",
              desc: "Number of bytes"
            }
          ]
        },
        { name: "status",
          desc: "DMA Status",
          swaccess: "ro",
          hwaccess: "hwo",
          hwext: "true",
          fields: [
            { bits: "0",
              name: "busy",
              desc: "DMA busy"
            }
          ]
        },
        { name: "next_id",
          desc: "Next ID, launches transfer, returns 0 if transfer not set up properly.",
          swaccess: "ro",
          hwaccess: "hrw",
          hwext: "true",
          hwre: "true",
          fields: [
            { bits: "63:0",
              name: "next_id",
              desc: "Next ID, launches transfer, returns 0 if transfer not set up properly."
            }
          ]
        },
        { name: "done",
          desc: "Get ID of finished transactions.",
          swaccess: "ro",
          hwaccess: "hrw",
          hwext: "true",
          hwre: "true",
          fields: [
            { bits: "63:0",
              name: "done",
              desc: "Get ID of finished transactions."
            }
          ]
        }
  ]
}





